simulator lang=spectre
Vclk (clk 0) vsource type=pulse val0=0 val1=1.0 period=40n delay=0 rise=0.1n fall=0.1n width=20n
Vwrite_en (write_en 0) vsource type=pulse val0=0 val1=1.0 period=320n delay=0 rise=0.1n fall=0.1n width=160n
Vsense_en (sense_en 0) vsource type=pulse val0=0 val1=1.0 period=40n delay=185n rise=0.1n fall=0.1n width=10n
Vaddr0 (addr0 0) vsource type=pulse val0=0 val1=1.0 period=80n delay=40n rise=0.1n fall=0.1n width=40n
Vaddr1 (addr1 0) vsource type=pulse val0=0 val1=1.0 period=160n delay=40n rise=0.1n fall=0.1n width=80n
Vaddr2 (addr2 0) vsource type=dc dc=0
Vaddr3 (addr3 0) vsource type=dc dc=0
Vaddr4 (addr4 0) vsource type=dc dc=0
Vaddr5 (addr5 0) vsource type=dc dc=0
Vaddr6 (addr6 0) vsource type=dc dc=0
Vaddr7 (addr7 0) vsource type=dc dc=0
Vdin0 (din0 0) vsource type=pulse val0=0 val1=1.0 period=80n delay=40n rise=0.1n fall=0.1n width=40n
Vdin1 (din1 0) vsource type=pulse val0=0 val1=1.0 period=160n delay=40n rise=0.1n fall=0.1n width=80n
Vdin2 (din2 0) vsource type=pulse val0=0 val1=1.0 period=240n delay=40n rise=0.1n fall=0.1n width=120n
Vdin3 (din3 0) vsource type=pulse val0=0 val1=1.0 period=320n delay=40n rise=0.1n fall=0.1n width=160n
Vdin4 (din4 0) vsource type=pulse val0=0 val1=1.0 period=400n delay=40n rise=0.1n fall=0.1n width=200n
Vdin5 (din5 0) vsource type=pulse val0=0 val1=1.0 period=480n delay=40n rise=0.1n fall=0.1n width=240n
Vdin6 (din6 0) vsource type=pulse val0=0 val1=1.0 period=560n delay=40n rise=0.1n fall=0.1n width=280n
Vdin7 (din7 0) vsource type=pulse val0=0 val1=1.0 period=640n delay=40n rise=0.1n fall=0.1n width=320n
Vdin8 (din8 0) vsource type=pulse val0=0 val1=1.0 period=720n delay=40n rise=0.1n fall=0.1n width=360n
Vdin9 (din9 0) vsource type=pulse val0=0 val1=1.0 period=800n delay=40n rise=0.1n fall=0.1n width=400n
Vdin10 (din10 0) vsource type=pulse val0=0 val1=1.0 period=880n delay=40n rise=0.1n fall=0.1n width=440n
Vdin11 (din11 0) vsource type=pulse val0=0 val1=1.0 period=960n delay=40n rise=0.1n fall=0.1n width=480n
Vdin12 (din12 0) vsource type=pulse val0=0 val1=1.0 period=1040n delay=40n rise=0.1n fall=0.1n width=520n
Vdin13 (din13 0) vsource type=pulse val0=0 val1=1.0 period=1120n delay=40n rise=0.1n fall=0.1n width=560n
Vdin14 (din14 0) vsource type=pulse val0=0 val1=1.0 period=1200n delay=40n rise=0.1n fall=0.1n width=600n
Vdin15 (din15 0) vsource type=pulse val0=0 val1=1.0 period=1280n delay=40n rise=0.1n fall=0.1n width=640n
Vdin16 (din16 0) vsource type=pulse val0=0 val1=1.0 period=1360n delay=40n rise=0.1n fall=0.1n width=680n
Vdin17 (din17 0) vsource type=pulse val0=0 val1=1.0 period=1440n delay=40n rise=0.1n fall=0.1n width=720n
Vdin18 (din18 0) vsource type=pulse val0=0 val1=1.0 period=1520n delay=40n rise=0.1n fall=0.1n width=760n
Vdin19 (din19 0) vsource type=pulse val0=0 val1=1.0 period=1600n delay=40n rise=0.1n fall=0.1n width=800n
Vdin20 (din20 0) vsource type=pulse val0=0 val1=1.0 period=1680n delay=40n rise=0.1n fall=0.1n width=840n
Vdin21 (din21 0) vsource type=pulse val0=0 val1=1.0 period=1760n delay=40n rise=0.1n fall=0.1n width=880n
Vdin22 (din22 0) vsource type=pulse val0=0 val1=1.0 period=1840n delay=40n rise=0.1n fall=0.1n width=920n
Vdin23 (din23 0) vsource type=pulse val0=0 val1=1.0 period=1920n delay=40n rise=0.1n fall=0.1n width=960n
Vdin24 (din24 0) vsource type=pulse val0=0 val1=1.0 period=2000n delay=40n rise=0.1n fall=0.1n width=1000n
Vdin25 (din25 0) vsource type=pulse val0=0 val1=1.0 period=2080n delay=40n rise=0.1n fall=0.1n width=1040n
Vdin26 (din26 0) vsource type=pulse val0=0 val1=1.0 period=2160n delay=40n rise=0.1n fall=0.1n width=1080n
Vdin27 (din27 0) vsource type=pulse val0=0 val1=1.0 period=2240n delay=40n rise=0.1n fall=0.1n width=1120n
Vdin28 (din28 0) vsource type=pulse val0=0 val1=1.0 period=2320n delay=40n rise=0.1n fall=0.1n width=1160n
Vdin29 (din29 0) vsource type=pulse val0=0 val1=1.0 period=2400n delay=40n rise=0.1n fall=0.1n width=1200n
Vdin30 (din30 0) vsource type=pulse val0=0 val1=1.0 period=2480n delay=40n rise=0.1n fall=0.1n width=1240n
Vdin31 (din31 0) vsource type=pulse val0=0 val1=1.0 period=2560n delay=40n rise=0.1n fall=0.1n width=1280n
Vvdd (vdd! 0) vsource type=dc dc=1.0
Vgnd (gnd! 0) vsource type=dc dc=0
